ADE simulation setup
Test demo_k_ratio_1: demo/k_ratio/schematic, simulator spectre
  Models: /home/viterbi/01/ee577/CDS_GPDK45/gpdk045_v_5_0/gpdk045/../models/spectre/gpdk045.scs[mc]
  Variables: w_p = 120n
  Temperature: 27
  Stimulus in: voltage bit val1=1 val0=0 rise=10p fall=10p period=1n data=0101
  Stimulus vdd!: voltage dc dc=1
  Analysis tran: stop=10n
  Signals: /in, /out
Run mode: Single Run, Sweeps and Corners
Setup values for test demo_k_ratio_1: w_p = 120n:60n:240n
