ADE simulation setup
Run mode: Single Run, Sweeps and Corners
Tests:
  demo_k_ratio_1: demo/k_ratio/schematic, simulator spectre
    Variables: w_p = 120n:60n:240n
    Outputs: /in; /out
