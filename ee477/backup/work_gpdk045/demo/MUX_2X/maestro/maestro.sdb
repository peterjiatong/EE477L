ADE simulation setup
Run mode: Single Run, Sweeps and Corners
Tests:
  demo_MUX_2X_1: demo/MUX_2X/schematic, simulator spectre
    Outputs: /A; /B; /S; /Out
