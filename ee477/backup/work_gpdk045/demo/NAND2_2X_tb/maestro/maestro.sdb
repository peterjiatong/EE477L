ADE simulation setup
Run mode: Single Run, Sweeps and Corners
Tests:
  demo_NAND2_2X_tb_1: demo/NAND2_2X_tb/config, simulator spectre
    Outputs: /in_a; /in_b; /out
