ADE simulation setup
Test demo_4bit_CSA_tb_1: demo/4bit_CSA_tb/schematic, simulator spectre
  Models: /home/viterbi/01/ee577/CDS_GPDK45/gpdk045_v_5_0/gpdk045/../models/spectre/gpdk045.scs[mc]
  Temperature: 27
  Files: vectors /home/viterbi/01/tongjia/work_gpdk045/vector_files/file_sample_4-bit.vec
  Stimulus B2_b: voltage bit val1=1 val0=0 rise=10p fall=10p period=1n data=1100101
  Stimulus B3_b: voltage bit val1=1 val0=0 rise=10p fall=10p period=1n data=1110101
  Stimulus C0_b: voltage bit val1=1 val0=0 rise=10p fall=10p period=1n data=1100111
  Stimulus B0_b: voltage bit val1=1 val0=0 rise=10p fall=10p period=1n data=1001101
  Stimulus B1_b: voltage bit val1=1 val0=0 rise=10p fall=10p period=1n data=1010001
  Stimulus A2_b: voltage bit val1=1 val0=0 rise=10p fall=10p period=1n data=1111101
  Stimulus A1_b: voltage bit val1=1 val0=0 rise=10p fall=10p period=1n data=1011101
  Stimulus A3_b: voltage bit val1=1 val0=0 rise=10p fall=10p period=1n data=1111001
  Stimulus A0_b: voltage bit val1=1 val0=0 rise=10p fall=10p period=1n data=1101001
  Stimulus vdd!: voltage dc dc=1
  Analysis tran: stop=10n
  Signals: /A1, /A2, /A3, /A0, /B1, /B2, /B3, /B0, /C0, /S1, /S2, /S3, /S0, /Cout, /p
Run mode: Single Run, Sweeps and Corners
