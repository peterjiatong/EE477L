ADE simulation setup
Run mode: Single Run, Sweeps and Corners
Tests:
  demo_4bit_CSA_tb_1: demo/4bit_CSA_tb/schematic, simulator spectre
    Outputs: /A0; /A1; /A2; /A3; /B0; /B1; /B2; /B3; /C0; /S0; /S1; /S2; /S3; /Cout; /p
