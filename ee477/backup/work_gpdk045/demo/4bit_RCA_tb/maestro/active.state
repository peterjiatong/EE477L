ADE simulation setup
Test demo_4bit_RCA_tb_1: demo/4bit_RCA_tb/schematic, simulator spectre
  Models: /home/viterbi/01/ee577/CDS_GPDK45/gpdk045_v_5_0/gpdk045/../models/spectre/gpdk045.scs[mc]
  Temperature: 27
  Stimulus A2_b: voltage bit val1=1 val0=0 rise=10p fall=10p period=1n data=1111101
  Stimulus A3_b: voltage bit val1=1 val0=0 rise=10p fall=10p period=1n data=1111001
  Stimulus B0_b: voltage bit val1=1 val0=0 rise=10p fall=10p period=1n data=1001101
  Stimulus B1_b: voltage bit val1=1 val0=0 rise=10p fall=10p period=1n data=1010001
  Stimulus B2_b: voltage bit val1=1 val0=0 rise=10p fall=10p period=1n data=1100101
  Stimulus B3_b: voltage bit val1=1 val0=0 rise=10p fall=10p period=1n data=1110101
  Stimulus C0_b: voltage bit val1=1 val0=0 rise=10p fall=10p period=1n data=1100111
  Stimulus A0_b: voltage bit val1=1 val0=0 rise=10p fall=10p period=1n data=1101001
  Stimulus A1_b: voltage bit val1=1 val0=0 rise=10p fall=10p period=1n data=1011101
  Stimulus vdd!: voltage dc dc=1
  Analysis tran: stop=10n
  Signals: /S0, /S1, /S2, /S3, /C4, /A0, /A1, /A2, /A3, /B0, /B1, /B2, /B3, /C0
Run mode: Single Run, Sweeps and Corners
