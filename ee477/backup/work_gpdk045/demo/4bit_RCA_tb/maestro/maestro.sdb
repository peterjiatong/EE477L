ADE simulation setup
Run mode: Single Run, Sweeps and Corners
Tests:
  demo_4bit_RCA_tb_1: demo/4bit_RCA_tb/schematic, simulator spectre
    Outputs: /S0; /S1; /S2; /S3; /C4; /A0; /A1; /A2; /A3; /B0; /B1; /B2; /B3; /C0
