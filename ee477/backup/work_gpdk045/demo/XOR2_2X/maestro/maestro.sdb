ADE simulation setup
Run mode: Single Run, Sweeps and Corners
Tests:
  demo_XOR2_2X_1: demo/XOR2_2X/schematic, simulator spectre
    Outputs: /A; /B; /OUT
