ADE simulation setup
Test EE477L_XOR2_1X_Power_tb_1: demo/XOR2_1X_Power_tb/schematic, simulator spectre
  Models: /home/viterbi/01/ee577/CDS_GPDK45/gpdk045_v_5_0/gpdk045/../models/spectre/gpdk045.scs[mc]
  Temperature: 27
  Stimulus A: voltage dc dc=1
  Stimulus B: voltage pulse dc=1 val0=0 val1=1 period=4n rise=5p fall=5p width=2n
  Analysis tran: stop=10n
  Output clip(IT("/V0/PLUS") 2e-09 6e-09)
  Signals: /A, /B, /OUT, /V0/PLUS (terminal)
Run mode: Single Run, Sweeps and Corners
