ADE simulation setup
Run mode: Single Run, Sweeps and Corners
Tests:
  EE477L_XOR2_1X_Power_tb_1: demo/XOR2_1X_Power_tb/schematic, simulator spectre
    Outputs: /A; /B; /OUT
