ADE simulation setup
Run mode: Single Run, Sweeps and Corners
Tests:
  demo_MUX_4X_1: demo/MUX_4X/schematic, simulator spectre
    Outputs: /A; /B; /S; /Out
