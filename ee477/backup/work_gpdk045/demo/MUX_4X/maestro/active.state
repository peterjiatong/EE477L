ADE simulation setup
Test demo_MUX_4X_1: demo/MUX_4X/schematic, simulator spectre
  Models: /home/viterbi/01/ee577/CDS_GPDK45/gpdk045_v_5_0/gpdk045/../models/spectre/gpdk045.scs[mc]
  Temperature: 27
  Stimulus vdd!: voltage dc dc=1
  Stimulus A: voltage bit val1=1 val0=0 rise=10p fall=10p period=1n data=00001111
  Stimulus B: voltage bit val1=1 val0=0 rise=10p fall=10p period=1n data=00110011
  Stimulus S: voltage bit val1=1 val0=0 rise=10p fall=10p period=1n data=01010101
  Analysis tran: stop=10n
  Signals: /A, /B, /S, /Out
Run mode: Single Run, Sweeps and Corners
