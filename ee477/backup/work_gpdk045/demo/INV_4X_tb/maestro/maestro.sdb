ADE simulation setup
Run mode: Single Run, Sweeps and Corners
Tests:
  demo_INV_4X_tb_1: demo/INV_4X_tb/schematic, simulator spectre
    Outputs: /in; /out
