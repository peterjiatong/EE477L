ADE simulation setup
Test demo_INV_4X_tb_1: demo/INV_4X_tb/schematic, simulator spectre
  Models: /home/viterbi/01/ee577/CDS_GPDK45/gpdk045_v_5_0/gpdk045/../models/spectre/gpdk045.scs[mc]
  Temperature: 27
  Stimulus vdd!: voltage dc dc=1
  Stimulus in_b: voltage bit val1=1 val0=0 rise=10p fall=10p period=1n data=01010
  Analysis tran: stop=10n
  Signals: /in, /out
Run mode: Single Run, Sweeps and Corners
