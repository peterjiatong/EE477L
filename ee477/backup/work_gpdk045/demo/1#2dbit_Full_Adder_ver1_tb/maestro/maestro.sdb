ADE simulation setup
Run mode: Single Run, Sweeps and Corners
Tests:
  demo_1-bit_Full_Adder_ver1_tb_1: demo/1-bit_Full_Adder_ver1_tb/schematic, simulator spectre
    Outputs: /A; /B; /Cin; /S; /Cout
