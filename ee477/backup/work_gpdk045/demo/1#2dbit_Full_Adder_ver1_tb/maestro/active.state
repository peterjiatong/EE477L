ADE simulation setup
Test demo_1-bit_Full_Adder_ver1_tb_1: demo/1-bit_Full_Adder_ver1_tb/schematic, simulator spectre
  Models: /home/viterbi/01/ee577/CDS_GPDK45/gpdk045_v_5_0/gpdk045/../models/spectre/gpdk045.scs[mc]
  Temperature: 27
  Stimulus vdd!: voltage dc dc=1
  Stimulus B_b: voltage bit val1=1 val0=0 rise=10p fall=10p period=1n data=00001100
  Stimulus Cin_b: voltage bit val1=1 val0=0 rise=10p fall=10p period=1n data=10011001
  Stimulus A_b: voltage bit val1=1 val0=0 rise=10p fall=10p period=1n data=11110000
  Analysis tran: stop=10n
  Signals: /A, /B, /Cin, /S, /Cout
Run mode: Single Run, Sweeps and Corners
