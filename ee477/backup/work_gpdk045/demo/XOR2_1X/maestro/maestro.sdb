ADE simulation setup
Run mode: Single Run, Sweeps and Corners
Tests:
  demo_XOR2_1X_1: demo/XOR2_1X/schematic, simulator spectre
    Outputs: /A; /B; /OUT
