ADE simulation setup
Run mode: Single Run, Sweeps and Corners
Tests:
  demo_INV_1X_tb_1: demo/INV_1X_tb/config, simulator spectre
    Outputs: /in; /out
