ADE simulation setup
Run mode: Single Run, Sweeps and Corners
Tests:
  demo_1_bit_Full_Adder_ver1_1: demo/1_bit_Full_Adder_ver1/schematic, simulator spectre
    Outputs: /A; /B; /Cin; /S; /Cout
