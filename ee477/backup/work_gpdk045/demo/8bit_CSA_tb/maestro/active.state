ADE simulation setup
Test demo_8bit_CSA_tb_1: demo/8bit_CSA_tb/config, simulator spectre
  Models: /home/viterbi/01/ee577/CDS_GPDK45/gpdk045_v_5_0/gpdk045/../models/spectre/gpdk045.scs[mc]
  Temperature: 27
  Files: vectors /home/viterbi/01/tongjia/work_gpdk045/vector_files/file_simple_8-bit.vec
  Stimulus vdd!: voltage dc dc=1
  Analysis tran: stop=10n
  Signals: /A0, /A1, /A2, /A3, /A4, /A5, /A6, /A7, /B0, /B1, /B2, /B3, /B4, /B5, /B6, /B7, /Cin, /Cout, /S0, /S1, /S2, /S3, /S4, /S5, /S6, /S7
Run mode: Single Run, Sweeps and Corners
