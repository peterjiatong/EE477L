ADE simulation setup
Run mode: Single Run, Sweeps and Corners
Tests:
  demo_8bit_CSA_tb_1: demo/8bit_CSA_tb/config, simulator spectre
    Outputs: /A0; /A1; /A2; /A3; /A4; /A5; /A6; /A7; /B0; /B1; /B2; /B3; /B4; /B5; /B6; /B7; /Cin; /Cout; /S0; /S1; /S2; /S3; /S4; /S5; /S6; /S7
