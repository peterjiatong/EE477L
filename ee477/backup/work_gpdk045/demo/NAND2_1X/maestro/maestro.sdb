ADE simulation setup
Run mode: Single Run, Sweeps and Corners
Tests:
  demo_NAND2_1X_1: demo/NAND2_1X/schematic, simulator spectre
    Outputs: /in_a; /in_b; /out
