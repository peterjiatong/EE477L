ADE simulation setup
Test demo_NAND2_1X_1: demo/NAND2_1X/schematic, simulator spectre
  Models: /home/viterbi/01/ee577/CDS_GPDK45/gpdk045_v_5_0/gpdk045/../models/spectre/gpdk045.scs[mc]
  Temperature: 27
  Stimulus vdd!: voltage dc dc=1
  Stimulus in_a: voltage bit val1=1 val0=0 rise=10p fall=10p period=1n data=1100
  Stimulus in_b: voltage bit val1=1 val0=0 rise=10p fall=10p period=1n data=1010
  Analysis tran: stop=10n
  Signals: /in_a, /in_b, /out
Run mode: Single Run, Sweeps and Corners
