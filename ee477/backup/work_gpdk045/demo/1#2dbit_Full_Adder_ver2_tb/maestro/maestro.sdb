ADE simulation setup
Run mode: Single Run, Sweeps and Corners
Tests:
  demo_1-bit_Full_Adder_ver2_tb_1: demo/1-bit_Full_Adder_ver2_tb/config, simulator spectre
    Outputs: /Cin; /S; /Cout; /A; /B; /A_b; /B_b
