ADE simulation setup
Test demo_AND4_1x_tb_1: demo/AND4_1x_tb/schematic, simulator spectre
  Models: /home/viterbi/01/ee577/CDS_GPDK45/gpdk045_v_5_0/gpdk045/../models/spectre/gpdk045.scs[mc]
  Temperature: 27
  Stimulus A: voltage bit val1=1 val0=0 rise=10p fall=10p period=1n data=11110000
  Stimulus B: voltage bit val1=1 val0=0 rise=10p fall=10p period=1n data=11001100
  Stimulus C: voltage bit val1=1 val0=0 rise=10p fall=10p period=1n data=11101000
  Stimulus D: voltage bit val1=1 val0=0 rise=10p fall=10p period=1n data=01010101
  Stimulus vdd!: voltage dc dc=1
  Analysis tran: stop=10n
  Signals: /Ai, /Bi, /Ci, /Di, /Outi
Run mode: Single Run, Sweeps and Corners
