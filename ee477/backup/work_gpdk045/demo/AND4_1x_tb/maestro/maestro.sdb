ADE simulation setup
Run mode: Single Run, Sweeps and Corners
Tests:
  demo_AND4_1x_tb_1: demo/AND4_1x_tb/schematic, simulator spectre
    Outputs: /A; /B; /Ci; /Ai; /Bi; /Di; /Outi
