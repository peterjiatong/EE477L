ADE simulation setup
Test demo_NOR2_2X_tb_1: demo/NOR2_2X_tb/schematic, simulator spectre
  Models: /home/viterbi/01/ee577/CDS_GPDK45/gpdk045_v_5_0/gpdk045/../models/spectre/gpdk045.scs[mc]
  Temperature: 27
  Stimulus in_a_b: voltage bit val1=1 val0=0 rise=10p fall=10p period=1n data=01110
  Stimulus in_b_b: voltage bit val1=1 val0=0 rise=10p fall=10p period=1n data=11011
  Stimulus vdd!: voltage dc dc=1
  Analysis tran: stop=10n
  Signals: /in_a, /in_b, /out
Run mode: Single Run, Sweeps and Corners
