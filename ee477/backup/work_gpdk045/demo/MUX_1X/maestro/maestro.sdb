ADE simulation setup
Run mode: Single Run, Sweeps and Corners
Tests:
  demo_MUX_1X_1: demo/MUX_1X/schematic, simulator spectre
    Outputs: /A; /B; /S; /Out
