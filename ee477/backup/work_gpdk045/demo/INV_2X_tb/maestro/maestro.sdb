ADE simulation setup
Run mode: Single Run, Sweeps and Corners
Tests:
  demo_INV_2X_tb_1: demo/INV_2X_tb/config, simulator spectre
    Outputs: /in; /out
